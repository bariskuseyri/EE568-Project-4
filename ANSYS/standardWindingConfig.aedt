# Ansys Electronics Desktop project, version 2020.1
materials:
  XG196/96: permeability{HUnit=A_per_meter BUnit=tesla curve (-690000, 0) (-663113.52, 0.048797862) (-635337.77, 0.097595724) (-606627.88, 0.14639359) (-576935.93, 0.19519145) (-546210.65, 0.24398931) (-514397.15, 0.29278717) (-481436.56, 0.34158503) (-447265.71, 0.39038289) (-411816.7, 0.43918076) (-375016.43, 0.48797862) (-333347.94, 0.54110533) (-291679.45, 0.5934675) (-250010.95, 0.64582967) (-208342.46, 0.69819184) (-166673.97, 0.75055402) (-125005.48, 0.80291619) (-83336.985, 0.85527836) (-41668.492, 0.90764053) (0, 0.96)}
  M19_24G: permeability{HUnit=A_per_meter BUnit=tesla curve (0, 0) (22.28, 0.05) (25.46, 0.1) (31.83, 0.15) (47.74, 0.36) (63.66, 0.54) (79.57, 0.65) (159.15, 0.99) (318.3, 1.2) (477.46, 1.28) (636.61, 1.33) (795.77, 1.36) (1591.5, 1.44) (3183, 1.52) (4774.6, 1.58) (6366.1, 1.63) (7957.7, 1.67) (15915, 1.8) (31830, 1.9) (111407, 2) (190984, 2.1) (350138, 2.3) (509292, 2.5)} conductivity=1960000 core_loss_type="Electrical Steel" core_loss_kh=164.2 core_loss_kc=1.3 core_loss_ke=1.72 mass_density=7650
  NdFe35: permittivity=1 permeability=1.0997785 conductivity=625000 magnetic_coercivity{Magnitude=-890000A_per_meter DirComp1=1 DirComp2=0 DirComp3=0} lande_g_factor=2 mass_density=7400
  lead: permeability=0.999983 conductivity=5000000 mass_density=11336
  AK Steel - M-15, 14mil, 60Hz: core_loss_curve{50Hz (0, 0) (0.1, 0.01) (0.2, 0.02) (0.3, 0.03) (0.4, 0.0352) (0.5, 0.1677) (0.6, 0.3002) (0.7, 0.4339) (0.8, 0.6041) (0.9, 0.7744) (1, 0.9453) (1.1, 1.171) (1.2, 1.37) (1.3, 1.6) (1.4, 1.9772) (1.5, 2.4342) (1.6, 3.0439)} core_loss_curve{60Hz (0, 0) (0.1, 0.0415019) (0.2, 0.0830038) (0.3, 0.174242) (0.4, 0.287118) (0.5, 0.418219) (0.6, 0.565442) (0.7, 0.727709) (0.8, 0.904941) (0.9, 1.09831) (1, 1.31089) (1.1, 1.54909) (1.2, 1.82498) (1.3, 2.15911) (1.4, 2.57708) (1.5, 3.08) (1.6, 3.59014) (1.7, 3.99169) (1.8, 4.27175)} core_loss_curve{400Hz (0, 0) (0.1, 0.1108) (0.2, 0.6933) (0.3, 1.8402) (0.4, 2.992) (0.5, 4.7) (0.6, 6.5422) (0.7, 8.5788) (0.8, 10.8648) (0.9, 13.3028) (1, 15.8723) (1.1, 19.2924) (1.2, 23.0177) (1.3, 27.3126) (1.4, 32.2461) (1.5, 38.1193) (1.6, 44.6507)} core_loss_curve{600Hz (0, 0) (0.05, 1.5582) (0.1, 2.6008) (0.15, 2.6434) (0.2, 2.6861) (0.25, 2.7287) (0.3, 2.7714) (0.35, 2.814) (0.4, 4.4891) (0.45, 6.2502) (0.5, 8.0114) (0.55, 9.9814) (0.6, 11.9574) (0.65, 13.9333) (0.7, 16.1489) (0.75, 18.3658) (0.8, 21.3883) (0.85, 24.4667) (0.9, 27.5451) (0.95, 31.0449) (1, 34.551) (1.05, 39.0968) (1.1, 43.6931) (1.15, 48.2895) (1.2, 52.9292) (1.25, 57.5688) (1.3, 62.2085) (1.35, 68.705)} permeability{HUnit=A_per_meter BUnit=tesla curve (0, 0) (39.7885, 0.292639) (41.78, 0.312155) (43.7839, 0.332262) (45.8127, 0.353097) (47.8788, 0.37481) (49.976, 0.397361) (52.0235, 0.419874) (53.9217, 0.441184) (55.5713, 0.460045) (56.9141, 0.475635) (58.0581, 0.489081) (59.1522, 0.502086) (60.3459, 0.516433) (61.7551, 0.533586) (63.3632, 0.553443) (65.1205, 0.57549) (66.9773, 0.599176) (68.8921, 0.624026) (70.8567, 0.649967) (72.871, 0.675) (74.935, 0.7) (77.0446, 0.725) (79.1791, 0.75) (81.3136, 0.775) (83.4232, 0.8) (85.4997, 0.825) (87.601, 0.85) (89.8018, 0.875) (92.1767, 0.9) (94.7878, 0.925) (97.6476, 0.95) (100.756, 0.975) (104.113, 1) (107.709, 1.025) (111.491, 1.05) (115.397, 1.075) (119.366, 1.1) (123.396, 1.125) (127.738, 1.15) (132.701, 1.175) (138.597, 1.2) (145.819, 1.225) (155.092, 1.25) (167.226, 1.275) (183.027, 1.3) (203.74, 1.325) (232.348, 1.35) (272.271, 1.375) (326.929, 1.4) (400.175, 1.425) (497.605, 1.45) (625.249, 1.475) (789.139, 1.5) (995.127, 1.525) (1248.36, 1.55) (1553.82, 1.575) (1916.48, 1.6) (2340.16, 1.625) (2824.15, 1.65) (3366.58, 1.675) (3965.59, 1.7) (4611.41, 1.72474) (5262.78, 1.74793) (5870.49, 1.76803) (6385.39, 1.78347) (6803.93, 1.79328) (7305.09, 1.79867) (8113.49, 1.80144) (9453.75, 1.80338) (11481.5, 1.80593) (14076.7, 1.80919) (17050.1, 1.81293) (20212.6, 1.8169)} conductivity=2000000 saturation_mag=2.01tesla core_loss_type="Electrical Steel" core_loss_kh=72.3146 core_loss_kc=0.641475 mass_density=7650
  AK Steel - M-15, 14mil, 1000Hz: core_loss_curve{50Hz (0, 0) (0.1, 0.01) (0.2, 0.02) (0.3, 0.03) (0.4, 0.0352) (0.5, 0.1677) (0.6, 0.3002) (0.7, 0.4339) (0.8, 0.6041) (0.9, 0.7744) (1, 0.9453) (1.1, 1.171) (1.2, 1.37) (1.3, 1.6) (1.4, 1.9772) (1.5, 2.4342) (1.6, 3.0439)} core_loss_curve{60Hz (0, 0) (0.1, 0.0415019) (0.2, 0.0830038) (0.3, 0.174242) (0.4, 0.287118) (0.5, 0.418219) (0.6, 0.565442) (0.7, 0.727709) (0.8, 0.904941) (0.9, 1.09831) (1, 1.31089) (1.1, 1.54909) (1.2, 1.82498) (1.3, 2.15911) (1.4, 2.57708) (1.5, 3.08) (1.6, 3.59014) (1.7, 3.99169) (1.8, 4.27175)} core_loss_curve{400Hz (0, 0) (0.1, 0.1108) (0.2, 0.6933) (0.3, 1.8402) (0.4, 2.992) (0.5, 4.7) (0.6, 6.5422) (0.7, 8.5788) (0.8, 10.8648) (0.9, 13.3028) (1, 15.8723) (1.1, 19.2924) (1.2, 23.0177) (1.3, 27.3126) (1.4, 32.2461) (1.5, 38.1193) (1.6, 44.6507)} core_loss_curve{600Hz (0, 0) (0.05, 1.5582) (0.1, 2.6008) (0.15, 2.6434) (0.2, 2.6861) (0.25, 2.7287) (0.3, 2.7714) (0.35, 2.814) (0.4, 4.4891) (0.45, 6.2502) (0.5, 8.0114) (0.55, 9.9814) (0.6, 11.9574) (0.65, 13.9333) (0.7, 16.1489) (0.75, 18.3658) (0.8, 21.3883) (0.85, 24.4667) (0.9, 27.5451) (0.95, 31.0449) (1, 34.551) (1.05, 39.0968) (1.1, 43.6931) (1.15, 48.2895) (1.2, 52.9292) (1.25, 57.5688) (1.3, 62.2085) (1.35, 68.705)} permeability{HUnit=A_per_meter BUnit=tesla curve (0, 0) (47.802, 0.15) (58.8979, 0.2) (69.0523, 0.25) (78.8724, 0.3) (87.6819, 0.35) (96.2798, 0.4) (104.672, 0.45) (113.812, 0.5) (122.615, 0.55) (132.68, 0.6) (143.737, 0.65) (154.807, 0.7) (166.604, 0.75) (179.131, 0.8) (192.751, 0.85) (205.041, 0.9) (221.166, 0.95) (236.237, 1) (252.412, 1.05) (269.049, 1.1) (285.402, 1.15) (306.569, 1.2) (327.146, 1.25) (360, 1.3) (475.486, 1.35)} conductivity=2000000 saturation_mag=2.01tesla core_loss_type="Electrical Steel" core_loss_kh=72.3146 core_loss_kc=0.641475 mass_density=7650
  AK Steel - M-15, 14mil: core_loss_curve{50Hz (0, 0) (0.1, 0.01) (0.2, 0.02) (0.3, 0.03) (0.4, 0.0352) (0.5, 0.1677) (0.6, 0.3002) (0.7, 0.4339) (0.8, 0.6041) (0.9, 0.7744) (1, 0.9453) (1.1, 1.171) (1.2, 1.37) (1.3, 1.6) (1.4, 1.9772) (1.5, 2.4342) (1.6, 3.0439)} core_loss_curve{60Hz (0, 0) (0.1, 0.0415019) (0.2, 0.0830038) (0.3, 0.174242) (0.4, 0.287118) (0.5, 0.418219) (0.6, 0.565442) (0.7, 0.727709) (0.8, 0.904941) (0.9, 1.09831) (1, 1.31089) (1.1, 1.54909) (1.2, 1.82498) (1.3, 2.15911) (1.4, 2.57708) (1.5, 3.08) (1.6, 3.59014) (1.7, 3.99169) (1.8, 4.27175)} core_loss_curve{400Hz (0, 0) (0.1, 0.1108) (0.2, 0.6933) (0.3, 1.8402) (0.4, 2.992) (0.5, 4.7) (0.6, 6.5422) (0.7, 8.5788) (0.8, 10.8648) (0.9, 13.3028) (1, 15.8723) (1.1, 19.2924) (1.2, 23.0177) (1.3, 27.3126) (1.4, 32.2461) (1.5, 38.1193) (1.6, 44.6507)} core_loss_curve{600Hz (0, 0) (0.05, 1.5582) (0.1, 2.6008) (0.15, 2.6434) (0.2, 2.6861) (0.25, 2.7287) (0.3, 2.7714) (0.35, 2.814) (0.4, 4.4891) (0.45, 6.2502) (0.5, 8.0114) (0.55, 9.9814) (0.6, 11.9574) (0.65, 13.9333) (0.7, 16.1489) (0.75, 18.3658) (0.8, 21.3883) (0.85, 24.4667) (0.9, 27.5451) (0.95, 31.0449) (1, 34.551) (1.05, 39.0968) (1.1, 43.6931) (1.15, 48.2895) (1.2, 52.9292) (1.25, 57.5688) (1.3, 62.2085) (1.35, 68.705)} permeability{HUnit=A_per_meter BUnit=tesla curve (0, 0) (15.9356, 0.1) (31.8712, 0.2) (38.6004, 0.3) (44.8737, 0.4) (51.4369, 0.5) (58.7526, 0.6) (67.2449, 0.7) (77.4196, 0.8) (89.9991, 0.9) (106.201, 1) (128.547, 1.1) (163.753, 1.2) (234.832, 1.3) (435.253, 1.4) (1108.32, 1.5) (2801.2, 1.6) (5591.07, 1.7) (9708.76, 1.8) (16041.4, 1.9) (31313.3, 2) (88477, 2.1) (159968, 2.2)} conductivity=2000000 saturation_mag=2.01tesla core_loss_type="Electrical Steel" core_loss_kh=72.3146 core_loss_kc=0.641475 mass_density=7650
  Arnold_Magnetics_N35H_80C: permeability{HUnit=A_per_meter BUnit=tesla curve (-858000, -1.1158) (-855000, -0.4991) (-850000, -0.2252) (-838000, -0.0722) (-828000, -0.0253) (-818000, 0.0055) (-807000, 0.0295) (-797000, 0.0501) (-787000, 0.0686) (-777000, 0.0857) (-767000, 0.102) (-757000, 0.1177) (-747000, 0.1329) (-737000, 0.1478) (-727000, 0.1624) (-717000, 0.1768) (-706000, 0.1911) (-696000, 0.2052) (-686000, 0.2191) (-676000, 0.233) (-666000, 0.2468) (-656000, 0.2606) (-646000, 0.2743) (-636000, 0.2879) (-626000, 0.3015) (-616000, 0.3151) (-606000, 0.3286) (-595000, 0.3421) (-585000, 0.3555) (-575000, 0.369) (-565000, 0.3824) (-555000, 0.3958) (-545000, 0.4092) (-535000, 0.4225) (-525000, 0.4359) (-515000, 0.4492) (-505000, 0.4625) (-495000, 0.4759) (-484000, 0.4892) (-474000, 0.5025) (-464000, 0.5157) (-454000, 0.529) (-444000, 0.5423) (-434000, 0.5556) (-424000, 0.5688) (-414000, 0.5821) (-404000, 0.5953) (-394000, 0.6086) (-384000, 0.6218) (-373000, 0.635) (-363000, 0.6483) (-353000, 0.6615) (-343000, 0.6747) (-333000, 0.6879) (-323000, 0.7011) (-313000, 0.7143) (-303000, 0.7275) (-293000, 0.7408) (-283000, 0.754) (-273000, 0.7672) (-262000, 0.7803) (-252000, 0.7935) (-242000, 0.8067) (-232000, 0.8199) (-222000, 0.8331) (-212000, 0.8463) (-202000, 0.8595) (-192000, 0.8727) (-182000, 0.8858) (-172000, 0.899) (-161000, 0.9122) (-151000, 0.9254) (-141000, 0.9386) (-131000, 0.9517) (-121000, 0.9649) (-111000, 0.9781) (-101000, 0.9912) (-91000, 1.0044) (-81000, 1.0176) (-71000, 1.0307) (-61000, 1.0439) (-50000, 1.0571) (-40000, 1.0702) (-30000, 1.0834) (-20000, 1.0966) (-10000, 1.1097) (0, 1.1229)} conductivity=555555.5556 magnetic_coercivity{Magnitude=-913700A_per_meter DirComp1=1 DirComp2=0 DirComp3=0} mass_density=7500
  Arnold_Magnetics_N50H_60C: permeability{HUnit=A_per_meter BUnit=tesla curve (-969000, -1.2606) (-964000, -0.3547) (-960000, -0.1681) (-946000, -0.0105) (-935000, 0.0448) (-924000, 0.0809) (-912000, 0.1088) (-901000, 0.1326) (-889000, 0.1538) (-878000, 0.1735) (-867000, 0.1921) (-855000, 0.21) (-844000, 0.2274) (-832000, 0.2443) (-821000, 0.2609) (-810000, 0.2773) (-798000, 0.2934) (-787000, 0.3094) (-775000, 0.3253) (-764000, 0.341) (-753000, 0.3567) (-741000, 0.3723) (-730000, 0.3878) (-718000, 0.4032) (-707000, 0.4186) (-696000, 0.4339) (-684000, 0.4492) (-673000, 0.4645) (-661000, 0.4797) (-650000, 0.4949) (-639000, 0.5101) (-627000, 0.5253) (-616000, 0.5404) (-604000, 0.5555) (-593000, 0.5706) (-582000, 0.5857) (-570000, 0.6008) (-559000, 0.6158) (-547000, 0.6309) (-536000, 0.6459) (-525000, 0.6609) (-513000, 0.6759) (-502000, 0.6909) (-490000, 0.7059) (-479000, 0.7209) (-468000, 0.7359) (-456000, 0.7509) (-445000, 0.7658) (-433000, 0.7808) (-422000, 0.7958) (-410000, 0.8107) (-399000, 0.8257) (-388000, 0.8406) (-376000, 0.8555) (-365000, 0.8705) (-353000, 0.8854) (-342000, 0.9003) (-331000, 0.9153) (-319000, 0.9302) (-308000, 0.9451) (-296000, 0.96) (-285000, 0.9749) (-274000, 0.9898) (-262000, 1.0047) (-251000, 1.0196) (-239000, 1.0345) (-228000, 1.0494) (-217000, 1.0643) (-205000, 1.0792) (-194000, 1.0941) (-182000, 1.109) (-171000, 1.1239) (-160000, 1.1388) (-148000, 1.1537) (-137000, 1.1686) (-125000, 1.1834) (-114000, 1.1983) (-103000, 1.2132) (-91000, 1.2281) (-80000, 1.243) (-68000, 1.2578) (-57000, 1.2727) (-46000, 1.2876) (-34000, 1.3025) (-23000, 1.3173) (-11000, 1.3322) (0, 1.3471)} conductivity=555555.5556 magnetic_coercivity{Magnitude=-1089500A_per_meter DirComp1=1 DirComp2=0 DirComp3=0} mass_density=7500

design assm_24slot-22pole (RMxprt, Adjust-Speed Synchronous Machine, model units mm)
machine:
  Machine: FrictionLoss=0W WindLoss=0W ReferenceSpeed=2700rpm NumberOfPoles=22 RotorPosition=true ControlType=3 CircuitType=Y3
  Circuit: TriggerPulseWidth=120deg TransistorDrop=0V DiodeDrop=0V ModulationIndex=0.8 CarrierFrequencyTimes=60
  Stator: SkewWidth=0 NumberOfSlots=24 LaminationSectors=0 PressBoardThickness=0mm OuterDiameter=412.8mm InnerDiameter=267.2mm Length=44.6mm StackingFactor=0.95 SteelType="AK Steel - M-15, 14mil" SlotType=3
  Rotor: OuterDiameter=265.9mm InnerDiameter=100mm Length=44.6mm SteelType="AK Steel - M-15, 14mil" PoleType=5 StackingFactor=0.95
  Shaft:
  Stator Slot: Hs0=2mm Hs1=2mm Hs2=46.4mm Bs0=15.4mm Bs1=20mm Bs2=20mm Rs=5mm ParallelTooth ToothWidth=17.4mm
  Stator Winding: WindingType=Whole-Coiled WindingLayers=1 ParallelBranches=1 ConductorsPerSlot=29 CoilPitch=1 EndAdjustment=0mm BaseInnerRadius=0mm TipInnerDiameter=0mm EndClearance=0mm CoilWrap=0mm SlotLiner=0.3mm WedgeThickness=0mm LayerInsulation=0mm BottomInsulation=0mm LimitedFillFactor=0.75 WdgNumberofPriodicMultipler=1 NumberOfStrands=1 WireWrap=0mm InterturnInsulation=0mm WireDiameter=1.828mm WireWidth=0mm WireThickness=0mm Gauge=13
  Rotor Pole: Embrace=0.6 Offset=0mm ShaftDiameter=0mm Bridge=1mm Rib=2mm MagnetThickness=12mm MagnetWidth=22.1mm MagnetType=Arnold_Magnetics_N50H_60C
setups:
  Setup1: ASSM Motor RatedOutputPower=47000W RatedVoltage=2400V RatedSpeed=2700rpm OperatingTemperature=75cel LoadType=ConstPower RatedPowerFactor=0.75

design assm_24slot-26pole (RMxprt, Adjust-Speed Synchronous Machine, model units mm)
machine:
  Machine: FrictionLoss=0W WindLoss=0W ReferenceSpeed=2700rpm NumberOfPoles=26 RotorPosition=true ControlType=3 CircuitType=Y3
  Circuit: TriggerPulseWidth=120deg TransistorDrop=0V DiodeDrop=0V ModulationIndex=0.8 CarrierFrequencyTimes=60
  Stator: SkewWidth=0 NumberOfSlots=24 LaminationSectors=0 PressBoardThickness=0mm OuterDiameter=424.5mm InnerDiameter=274.7mm Length=42.2mm StackingFactor=0.95 SteelType="AK Steel - M-15, 14mil" SlotType=3
  Rotor: OuterDiameter=273.4mm InnerDiameter=100mm Length=42.2mm SteelType="AK Steel - M-15, 14mil" PoleType=5 StackingFactor=0.95
  Shaft:
  Stator Slot: Hs0=2mm Hs1=2mm Hs2=48mm Bs0=15.9mm Bs1=20mm Bs2=20mm Rs=5mm ParallelTooth ToothWidth=17.9mm
  Stator Winding: WindingType=Whole-Coiled WindingLayers=1 ParallelBranches=1 ConductorsPerSlot=29 CoilPitch=1 EndAdjustment=0mm BaseInnerRadius=0mm TipInnerDiameter=0mm EndClearance=0mm CoilWrap=0mm SlotLiner=0.3mm WedgeThickness=0mm LayerInsulation=0mm BottomInsulation=0mm LimitedFillFactor=0.75 WdgNumberofPriodicMultipler=1 NumberOfStrands=1 WireWrap=0mm InterturnInsulation=0mm WireDiameter=5.189mm WireWidth=0mm WireThickness=0mm Gauge=4
  Rotor Pole: Embrace=0.6 Offset=0mm ShaftDiameter=0mm Bridge=1mm Rib=2mm MagnetThickness=15mm MagnetWidth=19.2mm MagnetType=Arnold_Magnetics_N50H_60C
setups:
  Setup1: ASSM Motor RatedOutputPower=47000W RatedVoltage=2400V RatedSpeed=2700rpm OperatingTemperature=75cel LoadType=ConstPower RatedPowerFactor=0.75

design assm_24slot-16pole (RMxprt, Adjust-Speed Synchronous Machine, model units mm)
machine:
  Machine: FrictionLoss=0W WindLoss=0W ReferenceSpeed=2700rpm NumberOfPoles=16 RotorPosition=true ControlType=3 CircuitType=Y3
  Circuit: TriggerPulseWidth=120deg TransistorDrop=0V DiodeDrop=0V ModulationIndex=0.8 CarrierFrequencyTimes=60
  Stator: SkewWidth=0 NumberOfSlots=24 LaminationSectors=0 PressBoardThickness=0mm OuterDiameter=391.5mm InnerDiameter=253.4mm Length=49.6mm StackingFactor=0.95 SteelType="AK Steel - M-15, 14mil" SlotType=3
  Rotor: OuterDiameter=252.2mm InnerDiameter=100mm Length=49.6mm SteelType="AK Steel - M-15, 14mil" PoleType=5 StackingFactor=0.95
  Shaft:
  Stator Slot: Hs0=2mm Hs1=2mm Hs2=43.5mm Bs0=14mm Bs1=20mm Bs2=20mm Rs=5mm ParallelTooth ToothWidth=16.5mm
  Stator Winding: WindingType=Editor WindingLayers=1 ParallelBranches=1 ConductorsPerSlot=29 CoilPitch=1 EndAdjustment=0mm BaseInnerRadius=0mm TipInnerDiameter=0mm EndClearance=0mm CoilWrap=0mm SlotLiner=0.3mm WedgeThickness=0mm LayerInsulation=0mm BottomInsulation=0mm LimitedFillFactor=0.75 WdgNumberofPriodicMultipler=1 WdgConstantTurns Wdgcoil_turns(29, 29, 29, 29, 29, 29, 29, 29, 29, 29, 29, 29) Wdgcoil_name(A, B, C, A, B, C, A, B, C, A, B, C) Wdgcoil_go(1, 3, 5, 7, 9, 11, 13, 15, 17, 19, 21, 23) Wdgcoil_re(2, 4, 6, 8, 10, 12, 14, 16, 18, 20, 22, 24) NumberOfStrands=1 WireWrap=0mm InterturnInsulation=0mm WireDiameter=5.189mm WireWidth=0mm WireThickness=0mm Gauge=4
  Rotor Pole: Embrace=0.6 Offset=0mm ShaftDiameter=0mm Bridge=1mm Rib=2mm MagnetThickness=15mm MagnetWidth=28.7mm MagnetType=Arnold_Magnetics_N50H_60C
setups:
  Setup1: ASSM Motor RatedOutputPower=47000W RatedVoltage=2400V RatedSpeed=2700rpm OperatingTemperature=75cel LoadType=ConstPower RatedPowerFactor=0.75

design assm_24slot-28pole (RMxprt, Adjust-Speed Synchronous Machine, model units mm)
machine:
  Machine: FrictionLoss=0W WindLoss=0W ReferenceSpeed=2700rpm NumberOfPoles=28 RotorPosition=true ControlType=3 CircuitType=Y3
  Circuit: TriggerPulseWidth=120deg TransistorDrop=0V DiodeDrop=0V ModulationIndex=0.8 CarrierFrequencyTimes=60
  Stator: SkewWidth=0 NumberOfSlots=24 LaminationSectors=0 PressBoardThickness=0mm OuterDiameter=429.8mm InnerDiameter=278.1mm Length=41.2mm StackingFactor=0.95 SteelType="AK Steel - M-15, 14mil" SlotType=3
  Rotor: OuterDiameter=276.8mm InnerDiameter=100mm Length=41.2mm SteelType="AK Steel - M-15, 14mil" PoleType=5 StackingFactor=0.95
  Shaft:
  Stator Slot: Hs0=2mm Hs1=2mm Hs2=48.7mm Bs0=16.1mm Bs1=20mm Bs2=20mm Rs=5mm ParallelTooth ToothWidth=18.1mm
  Stator Winding: WindingType=Whole-Coiled WindingLayers=1 ParallelBranches=1 ConductorsPerSlot=29 CoilPitch=1 EndAdjustment=0mm BaseInnerRadius=0mm TipInnerDiameter=0mm EndClearance=0mm CoilWrap=0mm SlotLiner=0.3mm WedgeThickness=0mm LayerInsulation=0mm BottomInsulation=0mm LimitedFillFactor=0.75 WdgNumberofPriodicMultipler=1 NumberOfStrands=1 WireWrap=0mm InterturnInsulation=0mm WireDiameter=5.189mm WireWidth=0mm WireThickness=0mm Gauge=4
  Rotor Pole: Embrace=0.6 Offset=0mm ShaftDiameter=0mm Bridge=1mm Rib=2mm MagnetThickness=18mm MagnetWidth=18.1mm MagnetType=Arnold_Magnetics_N50H_60C
setups:
  Setup1: ASSM Motor RatedOutputPower=47000W RatedVoltage=2400V RatedSpeed=2700rpm OperatingTemperature=75cel LoadType=ConstPower RatedPowerFactor=0.75

design assm_24slot-20pole (RMxprt, Adjust-Speed Synchronous Machine, model units mm)
machine:
  Machine: FrictionLoss=0W WindLoss=0W ReferenceSpeed=2700rpm NumberOfPoles=20 RotorPosition=true ControlType=3 CircuitType=Y3
  Circuit: TriggerPulseWidth=120deg TransistorDrop=0V DiodeDrop=0V ModulationIndex=0.8 CarrierFrequencyTimes=60
  Stator: SkewWidth=0 NumberOfSlots=24 LaminationSectors=0 PressBoardThickness=0mm OuterDiameter=406.3mm InnerDiameter=263mm Length=46.1mm StackingFactor=0.95 SteelType="AK Steel - M-15, 14mil" SlotType=3
  Rotor: OuterDiameter=261.7mm InnerDiameter=100mm Length=46.1mm SteelType="AK Steel - M-15, 14mil" PoleType=5 StackingFactor=0.95
  Shaft:
  Stator Slot: Hs0=2mm Hs1=2mm Hs2=45.5mm Bs0=15.1mm Bs1=20mm Bs2=20mm Rs=5mm ParallelTooth ToothWidth=17.1mm
  Stator Winding: WindingType=Whole-Coiled WindingLayers=1 ParallelBranches=1 ConductorsPerSlot=29 CoilPitch=1 EndAdjustment=0mm BaseInnerRadius=0mm TipInnerDiameter=0mm EndClearance=0mm CoilWrap=0mm SlotLiner=0.3mm WedgeThickness=0mm LayerInsulation=0mm BottomInsulation=0mm LimitedFillFactor=0.75 WdgNumberofPriodicMultipler=1 NumberOfStrands=1 WireWrap=0mm InterturnInsulation=0mm WireDiameter=5.189mm WireWidth=0mm WireThickness=0mm Gauge=4
  Rotor Pole: Embrace=0.6 Offset=0mm ShaftDiameter=0mm Bridge=1mm Rib=2mm MagnetThickness=12mm MagnetWidth=23.9mm MagnetType=Arnold_Magnetics_N50H_60C
setups:
  Setup1: ASSM Motor RatedOutputPower=47000W RatedVoltage=2400V RatedSpeed=2700rpm OperatingTemperature=75cel LoadType=ConstPower RatedPowerFactor=0.75

design assm_21slot-22pole (RMxprt, Adjust-Speed Synchronous Machine, model units mm)
machine:
  Machine: FrictionLoss=0W WindLoss=0W ReferenceSpeed=2700rpm NumberOfPoles=22 RotorPosition=true ControlType=3 CircuitType=Y3
  Circuit: TriggerPulseWidth=120deg TransistorDrop=0V DiodeDrop=0V ModulationIndex=0.8 CarrierFrequencyTimes=60
  Stator: SkewWidth=0 NumberOfSlots=21 LaminationSectors=0 PressBoardThickness=0mm OuterDiameter=270.2mm InnerDiameter=189.3mm Length=43.4mm StackingFactor=0.95 SteelType="AK Steel - M-15, 14mil" SlotType=3
  Rotor: OuterDiameter=188.1mm InnerDiameter=100mm Length=43.4mm SteelType="AK Steel - M-15, 14mil" PoleType=5 StackingFactor=0.95
  Shaft:
  Stator Slot: Hs0=2mm Hs1=2mm Hs2=20mm Bs0=5mm Bs1=20mm Bs2=20mm Rs=5mm ParallelTooth ToothWidth=12.4mm
  Stator Winding: WindingType=Editor WindingLayers=1 ParallelBranches=1 ConductorsPerSlot=29 CoilPitch=1 EndAdjustment=0mm BaseInnerRadius=0mm TipInnerDiameter=0mm EndClearance=0mm CoilWrap=0mm SlotLiner=0.3mm WedgeThickness=0mm LayerInsulation=0mm BottomInsulation=0mm LimitedFillFactor=0.75 WdgNumberofPriodicMultipler=1 Wdgcoil_turns(29, 29, 29, 29, 29, 29, 29, 29, 29, 0) Wdgcoil_name(A, A, A, B, B, B, C, C, C, C) Wdgcoil_go(1, 3, 12, 8, 10, 19, 14, 16, 5, 5) Wdgcoil_re(21, 2, 13, 7, 9, 20, 15, 17, 6, 12) NumberOfStrands=1 WireWrap=0mm InterturnInsulation=0mm WireDiameter=5.189mm WireWidth=0mm WireThickness=0mm Gauge=4
  Rotor Pole: Embrace=0.8 Offset=0mm ShaftDiameter=0mm Bridge=1mm Rib=2mm MagnetThickness=10mm MagnetWidth=15mm MagnetType=NdFe35
setups:
  Setup1: ASSM Motor RatedOutputPower=47000W RatedVoltage=2400V RatedSpeed=2700rpm OperatingTemperature=75cel LoadType=ConstPower RatedPowerFactor=0.75

design assm_18slot-16pole (RMxprt, Adjust-Speed Synchronous Machine, model units mm)
machine:
  Machine: FrictionLoss=0W WindLoss=0W ReferenceSpeed=2700rpm NumberOfPoles=16 RotorPosition=true ControlType=3 CircuitType=Y3
  Circuit: TriggerPulseWidth=120deg TransistorDrop=0V DiodeDrop=0V ModulationIndex=0.8 CarrierFrequencyTimes=60
  Stator: SkewWidth=0 NumberOfSlots=18 LaminationSectors=0 PressBoardThickness=0mm OuterDiameter=398.5mm InnerDiameter=253.4mm Length=49.6mm StackingFactor=0.95 SteelType="AK Steel - M-15, 14mil" SlotType=3
  Rotor: OuterDiameter=252.2mm InnerDiameter=100mm Length=49.6mm SteelType="AK Steel - M-15, 14mil" PoleType=5 StackingFactor=0.95
  Shaft:
  Stator Slot: Hs0=2mm Hs1=2mm Hs2=41.5mm Bs0=20mm Bs1=20mm Bs2=20mm Rs=5mm ParallelTooth ToothWidth=22mm
  Stator Winding: WindingType=Editor WindingLayers=1 ParallelBranches=1 ConductorsPerSlot=29 CoilPitch=1 EndAdjustment=0mm BaseInnerRadius=0mm TipInnerDiameter=0mm EndClearance=0mm CoilWrap=0mm SlotLiner=0.3mm WedgeThickness=0mm LayerInsulation=0mm BottomInsulation=0mm LimitedFillFactor=0.75 WdgNumberofPriodicMultipler=1 WdgConstantTurns Wdgcoil_turns(29, 29, 29, 29, 29, 29, 29, 29, 29) Wdgcoil_name(A, -B, -B, C, -A, -A, B, -C, -C) Wdgcoil_go(1, 3, 5, 7, 9, 11, 13, 15, 17) Wdgcoil_re(2, 4, 6, 8, 10, 12, 14, 16, 18) NumberOfStrands=1 WireWrap=0mm InterturnInsulation=0mm WireDiameter=5.189mm WireWidth=0mm WireThickness=0mm Gauge=4
  Rotor Pole: Embrace=0.6 Offset=0mm ShaftDiameter=0mm Bridge=1mm Rib=2mm MagnetThickness=9mm MagnetWidth=28.7mm MagnetType=Arnold_Magnetics_N50H_60C
setups:
  Setup1: ASSM Motor RatedOutputPower=47000W RatedVoltage=1150V RatedSpeed=2700rpm OperatingTemperature=75cel LoadType=ConstPower RatedPowerFactor=0.75

design assm_18slot-20pole (RMxprt, Adjust-Speed Synchronous Machine, model units mm)
machine:
  Machine: FrictionLoss=0W WindLoss=0W ReferenceSpeed=2700rpm NumberOfPoles=20 RotorPosition=true ControlType=3 CircuitType=Y3
  Circuit: TriggerPulseWidth=120deg TransistorDrop=0V DiodeDrop=0V ModulationIndex=0.8 CarrierFrequencyTimes=60
  Stator: SkewWidth=0 NumberOfSlots=18 LaminationSectors=0 PressBoardThickness=0mm OuterDiameter=413.6mm InnerDiameter=263mm Length=46.1mm StackingFactor=0.95 SteelType="AK Steel - M-15, 14mil" SlotType=3
  Rotor: OuterDiameter=261.7mm InnerDiameter=100mm Length=46.1mm SteelType="AK Steel - M-15, 14mil" PoleType=5 StackingFactor=0.95
  Shaft:
  Stator Slot: Hs0=2mm Hs1=2mm Hs2=43.5mm Bs0=20.8mm Bs1=20mm Bs2=20mm Rs=5mm ParallelTooth ToothWidth=22.8mm
  Stator Winding: WindingType=Editor WindingLayers=1 ParallelBranches=1 ConductorsPerSlot=29 CoilPitch=1 EndAdjustment=0mm BaseInnerRadius=0mm TipInnerDiameter=0mm EndClearance=0mm CoilWrap=0mm SlotLiner=0.3mm WedgeThickness=0mm LayerInsulation=0mm BottomInsulation=0mm LimitedFillFactor=0.75 WdgNumberofPriodicMultipler=1 WdgConstantTurns Wdgcoil_turns(29, 29, 29, 29, 29, 29, 29, 29, 29) Wdgcoil_name(A, -C, -C, B, -A, -A, C, -B, -B) Wdgcoil_go(1, 3, 5, 7, 9, 11, 13, 15, 17) Wdgcoil_re(2, 4, 6, 8, 10, 12, 14, 16, 18) NumberOfStrands=1 WireWrap=0mm InterturnInsulation=0mm WireDiameter=5.189mm WireWidth=0mm WireThickness=0mm Gauge=4
  Rotor Pole: Embrace=0.6 Offset=0mm ShaftDiameter=0mm Bridge=1mm Rib=2mm MagnetThickness=11mm MagnetWidth=23.9mm MagnetType=Arnold_Magnetics_N50H_60C
setups:
  Setup1: ASSM Motor RatedOutputPower=47000W RatedVoltage=2200V RatedSpeed=2700rpm OperatingTemperature=75cel LoadType=ConstPower RatedPowerFactor=0.75

design assm_18slot-22pole (RMxprt, Adjust-Speed Synchronous Machine, model units mm)
machine:
  Machine: FrictionLoss=0W WindLoss=0W ReferenceSpeed=2700rpm NumberOfPoles=22 RotorPosition=true ControlType=3 CircuitType=Y3
  Circuit: TriggerPulseWidth=120deg TransistorDrop=0V DiodeDrop=0V ModulationIndex=0.8 CarrierFrequencyTimes=60
  Stator: SkewWidth=0 NumberOfSlots=18 LaminationSectors=0 PressBoardThickness=0mm OuterDiameter=420.2mm InnerDiameter=267.2mm Length=44.6mm StackingFactor=0.95 SteelType="AK Steel - M-15, 14mil" SlotType=3
  Rotor: OuterDiameter=265.9mm InnerDiameter=100mm Length=44.6mm SteelType="AK Steel - M-15, 14mil" PoleType=5 StackingFactor=0.95
  Shaft:
  Stator Slot: Hs0=2mm Hs1=2mm Hs2=44.3mm Bs0=21.2mm Bs1=20mm Bs2=20mm Rs=5mm ParallelTooth ToothWidth=23.2mm
  Stator Winding: WindingType=Editor WindingLayers=1 ParallelBranches=1 ConductorsPerSlot=29 CoilPitch=1 EndAdjustment=0mm BaseInnerRadius=0mm TipInnerDiameter=0mm EndClearance=0mm CoilWrap=0mm SlotLiner=0.3mm WedgeThickness=0mm LayerInsulation=0mm BottomInsulation=0mm LimitedFillFactor=0.75 WdgNumberofPriodicMultipler=1 WdgConstantTurns Wdgcoil_turns(29, 29, 29, 29, 29, 29, 29, 29, 29) Wdgcoil_name(A, -C, -A, C, -B, -C, B, -A, -B) Wdgcoil_go(1, 3, 5, 7, 9, 11, 13, 15, 17) Wdgcoil_re(2, 4, 6, 8, 10, 12, 14, 16, 18) NumberOfStrands=1 WireWrap=0mm InterturnInsulation=0mm WireDiameter=5.189mm WireWidth=0mm WireThickness=0mm Gauge=4
  Rotor Pole: Embrace=0.6 Offset=0mm ShaftDiameter=0mm Bridge=1mm Rib=2mm MagnetThickness=13mm MagnetWidth=22.1mm MagnetType=Arnold_Magnetics_N50H_60C
setups:
  Setup1: ASSM Motor RatedOutputPower=47000W RatedVoltage=2400V RatedSpeed=2700rpm OperatingTemperature=75cel LoadType=ConstPower RatedPowerFactor=0.75

design assm_18slot-26pole (RMxprt, Adjust-Speed Synchronous Machine, model units mm)
machine:
  Machine: FrictionLoss=0W WindLoss=0W ReferenceSpeed=2700rpm NumberOfPoles=26 RotorPosition=true ControlType=3 CircuitType=Y3
  Circuit: TriggerPulseWidth=120deg TransistorDrop=0V DiodeDrop=0V ModulationIndex=0.8 CarrierFrequencyTimes=60
  Stator: SkewWidth=0 NumberOfSlots=18 LaminationSectors=0 PressBoardThickness=0mm OuterDiameter=432.1mm InnerDiameter=274.7mm Length=42.2mm StackingFactor=0.95 SteelType="AK Steel - M-15, 14mil" SlotType=3
  Rotor: OuterDiameter=273.4mm InnerDiameter=100mm Length=42.2mm SteelType="AK Steel - M-15, 14mil" PoleType=5 StackingFactor=0.95
  Shaft:
  Stator Slot: Hs0=2mm Hs1=2mm Hs2=44.3mm Bs0=21.2mm Bs1=20mm Bs2=20mm Rs=5mm ParallelTooth ToothWidth=23.2mm
  Stator Winding: WindingType=Editor WindingLayers=1 ParallelBranches=1 ConductorsPerSlot=29 CoilPitch=1 EndAdjustment=0mm BaseInnerRadius=0mm TipInnerDiameter=0mm EndClearance=0mm CoilWrap=0mm SlotLiner=0.3mm WedgeThickness=0mm LayerInsulation=0mm BottomInsulation=0mm LimitedFillFactor=0.75 WdgNumberofPriodicMultipler=1 WdgConstantTurns Wdgcoil_turns(29, 29, 29, 29, 29, 29, 29, 29, 29) Wdgcoil_name(A, -A, -B, B, -B, -C, C, -C, -A) Wdgcoil_go(1, 3, 5, 7, 9, 11, 13, 15, 17) Wdgcoil_re(2, 4, 6, 8, 10, 12, 14, 16, 18) NumberOfStrands=1 WireWrap=0mm InterturnInsulation=0mm WireDiameter=5.189mm WireWidth=0mm WireThickness=0mm Gauge=4
  Rotor Pole: Embrace=0.6 Offset=0mm ShaftDiameter=0mm Bridge=1mm Rib=2mm MagnetThickness=16mm MagnetWidth=19.2mm MagnetType=Arnold_Magnetics_N50H_60C
setups:
  Setup1: ASSM Motor RatedOutputPower=47000W RatedVoltage=2400V RatedSpeed=2700rpm OperatingTemperature=75cel LoadType=ConstPower RatedPowerFactor=0.75

design assm_18slot-28pole (RMxprt, Adjust-Speed Synchronous Machine, model units mm)
machine:
  Machine: FrictionLoss=0W WindLoss=0W ReferenceSpeed=2700rpm NumberOfPoles=28 RotorPosition=true ControlType=3 CircuitType=Y3
  Circuit: TriggerPulseWidth=120deg TransistorDrop=0V DiodeDrop=0V ModulationIndex=0.8 CarrierFrequencyTimes=60
  Stator: SkewWidth=0 NumberOfSlots=18 LaminationSectors=0 PressBoardThickness=0mm OuterDiameter=437.4mm InnerDiameter=278.1mm Length=41.2mm StackingFactor=0.95 SteelType="AK Steel - M-15, 14mil" SlotType=3
  Rotor: OuterDiameter=276.8mm InnerDiameter=100mm Length=41.2mm SteelType="AK Steel - M-15, 14mil" PoleType=5 StackingFactor=0.95
  Shaft:
  Stator Slot: Hs0=2mm Hs1=2mm Hs2=46.5mm Bs0=22.2mm Bs1=20mm Bs2=20mm Rs=5mm ParallelTooth ToothWidth=24.2mm
  Stator Winding: WindingType=Editor WindingLayers=1 ParallelBranches=1 ConductorsPerSlot=29 CoilPitch=1 EndAdjustment=0mm BaseInnerRadius=0mm TipInnerDiameter=0mm EndClearance=0mm CoilWrap=0mm SlotLiner=0.3mm WedgeThickness=0mm LayerInsulation=0mm BottomInsulation=0mm LimitedFillFactor=0.75 WdgNumberofPriodicMultipler=1 WdgConstantTurns Wdgcoil_turns(29, 29, 29, 29, 29, 29, 29, 29, 29) Wdgcoil_name(A, -A, -C, C, -C, -B, B, -B, -A) Wdgcoil_go(1, 3, 5, 7, 9, 11, 13, 15, 17) Wdgcoil_re(2, 4, 6, 8, 10, 12, 14, 16, 18) NumberOfStrands=1 WireWrap=0mm InterturnInsulation=0mm WireDiameter=5.189mm WireWidth=0mm WireThickness=0mm Gauge=4
  Rotor Pole: Embrace=0.6 Offset=0mm ShaftDiameter=0mm Bridge=1mm Rib=2mm MagnetThickness=20mm MagnetWidth=18.1mm MagnetType=Arnold_Magnetics_N50H_60C
setups:
  Setup1: ASSM Motor RatedOutputPower=47000W RatedVoltage=2400V RatedSpeed=2700rpm OperatingTemperature=75cel LoadType=ConstPower RatedPowerFactor=0.75
