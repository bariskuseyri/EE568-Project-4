# Ansys Electronics Desktop project, version 2020.1
materials:
  XG196/96: permeability{HUnit=A_per_meter BUnit=tesla curve (-690000, 0) (-663113.52, 0.048797862) (-635337.77, 0.097595724) (-606627.88, 0.14639359) (-576935.93, 0.19519145) (-546210.65, 0.24398931) (-514397.15, 0.29278717) (-481436.56, 0.34158503) (-447265.71, 0.39038289) (-411816.7, 0.43918076) (-375016.43, 0.48797862) (-333347.94, 0.54110533) (-291679.45, 0.5934675) (-250010.95, 0.64582967) (-208342.46, 0.69819184) (-166673.97, 0.75055402) (-125005.48, 0.80291619) (-83336.985, 0.85527836) (-41668.492, 0.90764053) (0, 0.96)}
  M19_24G: permeability{HUnit=A_per_meter BUnit=tesla curve (0, 0) (22.28, 0.05) (25.46, 0.1) (31.83, 0.15) (47.74, 0.36) (63.66, 0.54) (79.57, 0.65) (159.15, 0.99) (318.3, 1.2) (477.46, 1.28) (636.61, 1.33) (795.77, 1.36) (1591.5, 1.44) (3183, 1.52) (4774.6, 1.58) (6366.1, 1.63) (7957.7, 1.67) (15915, 1.8) (31830, 1.9) (111407, 2) (190984, 2.1) (350138, 2.3) (509292, 2.5)} conductivity=1960000 core_loss_type="Electrical Steel" core_loss_kh=164.2 core_loss_kc=1.3 core_loss_ke=1.72 mass_density=7650
  NdFe35: permittivity=1 permeability=1.0997785 conductivity=625000 magnetic_coercivity{Magnitude=-890000A_per_meter DirComp1=1 DirComp2=0 DirComp3=0} lande_g_factor=2 mass_density=7400

design assm-1 (RMxprt, Adjust-Speed Synchronous Machine, model units mm)
machine:
  Machine: FrictionLoss=0W WindLoss=0W ReferenceSpeed=2800rpm NumberOfPoles=22 RotorPosition=true ControlType=2 CircuitType=Y3
  Circuit: TriggerPulseWidth=120deg TransistorDrop=0V DiodeDrop=0V ModulationIndex=0.8 CarrierFrequencyTimes=60
  Stator: SkewWidth=0 NumberOfSlots=24 LaminationSectors=0 PressBoardThickness=0mm OuterDiameter=480mm InnerDiameter=291.4mm Length=68mm StackingFactor=0.95 SteelType=M19_24G SlotType=3
  Rotor: OuterDiameter=290mm InnerDiameter=100mm Length=68mm SteelType=M19_24G PoleType=5 StackingFactor=0.95
  Shaft:
  Stator Slot: Hs0=3mm Hs1=3mm Hs2=65mm Bs0=15mm Bs1=20mm Bs2=30mm Rs=10mm ToothWidth=0mm
  Stator Winding: WindingType=Whole-Coiled WindingLayers=1 ParallelBranches=1 ConductorsPerSlot=10 CoilPitch=1 EndAdjustment=0mm BaseInnerRadius=0mm TipInnerDiameter=0mm EndClearance=0mm CoilWrap=0mm SlotLiner=0.3mm WedgeThickness=0mm LayerInsulation=0mm BottomInsulation=0mm LimitedFillFactor=0.75 WdgNumberofPriodicMultipler=1 NumberOfStrands=1 WireWrap=0mm InterturnInsulation=0mm WireDiameter=5.189mm WireWidth=0mm WireThickness=0mm Gauge=4
  Rotor Pole: Embrace=0.8 Offset=0mm ShaftDiameter=0mm Bridge=1mm Rib=5mm MagnetThickness=10mm MagnetWidth=30mm MagnetType=NdFe35
setups:
  Setup1: ASSM Motor RatedOutputPower=47000W RatedVoltage=220V RatedSpeed=2700rpm OperatingTemperature=75cel LoadType=ConstPower RatedPowerFactor=0.75
