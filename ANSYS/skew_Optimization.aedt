# Ansys Electronics Desktop project, version 2020.1
materials:
  AK Steel - M-15, 14mil: core_loss_curve{50Hz (0, 0) (0.1, 0.01) (0.2, 0.02) (0.3, 0.03) (0.4, 0.0352) (0.5, 0.1677) (0.6, 0.3002) (0.7, 0.4339) (0.8, 0.6041) (0.9, 0.7744) (1, 0.9453) (1.1, 1.171) (1.2, 1.37) (1.3, 1.6) (1.4, 1.9772) (1.5, 2.4342) (1.6, 3.0439)} core_loss_curve{60Hz (0, 0) (0.1, 0.0415019) (0.2, 0.0830038) (0.3, 0.174242) (0.4, 0.287118) (0.5, 0.418219) (0.6, 0.565442) (0.7, 0.727709) (0.8, 0.904941) (0.9, 1.09831) (1, 1.31089) (1.1, 1.54909) (1.2, 1.82498) (1.3, 2.15911) (1.4, 2.57708) (1.5, 3.08) (1.6, 3.59014) (1.7, 3.99169) (1.8, 4.27175)} core_loss_curve{400Hz (0, 0) (0.1, 0.1108) (0.2, 0.6933) (0.3, 1.8402) (0.4, 2.992) (0.5, 4.7) (0.6, 6.5422) (0.7, 8.5788) (0.8, 10.8648) (0.9, 13.3028) (1, 15.8723) (1.1, 19.2924) (1.2, 23.0177) (1.3, 27.3126) (1.4, 32.2461) (1.5, 38.1193) (1.6, 44.6507)} core_loss_curve{600Hz (0, 0) (0.05, 1.5582) (0.1, 2.6008) (0.15, 2.6434) (0.2, 2.6861) (0.25, 2.7287) (0.3, 2.7714) (0.35, 2.814) (0.4, 4.4891) (0.45, 6.2502) (0.5, 8.0114) (0.55, 9.9814) (0.6, 11.9574) (0.65, 13.9333) (0.7, 16.1489) (0.75, 18.3658) (0.8, 21.3883) (0.85, 24.4667) (0.9, 27.5451) (0.95, 31.0449) (1, 34.551) (1.05, 39.0968) (1.1, 43.6931) (1.15, 48.2895) (1.2, 52.9292) (1.25, 57.5688) (1.3, 62.2085) (1.35, 68.705)} permeability{HUnit=A_per_meter BUnit=tesla curve (0, 0) (15.9356, 0.1) (31.8712, 0.2) (38.6004, 0.3) (44.8737, 0.4) (51.4369, 0.5) (58.7526, 0.6) (67.2449, 0.7) (77.4196, 0.8) (89.9991, 0.9) (106.201, 1) (128.547, 1.1) (163.753, 1.2) (234.832, 1.3) (435.253, 1.4) (1108.32, 1.5) (2801.2, 1.6) (5591.07, 1.7) (9708.76, 1.8) (16041.4, 1.9) (31313.3, 2) (88477, 2.1) (159968, 2.2)} conductivity=2000000 saturation_mag=2.01tesla core_loss_type="Electrical Steel" core_loss_kh=72.3146 core_loss_kc=0.641475 mass_density=7650
  Arnold_Magnetics_N50H_60C: permeability{HUnit=A_per_meter BUnit=tesla curve (-969000, -1.2606) (-964000, -0.3547) (-960000, -0.1681) (-946000, -0.0105) (-935000, 0.0448) (-924000, 0.0809) (-912000, 0.1088) (-901000, 0.1326) (-889000, 0.1538) (-878000, 0.1735) (-867000, 0.1921) (-855000, 0.21) (-844000, 0.2274) (-832000, 0.2443) (-821000, 0.2609) (-810000, 0.2773) (-798000, 0.2934) (-787000, 0.3094) (-775000, 0.3253) (-764000, 0.341) (-753000, 0.3567) (-741000, 0.3723) (-730000, 0.3878) (-718000, 0.4032) (-707000, 0.4186) (-696000, 0.4339) (-684000, 0.4492) (-673000, 0.4645) (-661000, 0.4797) (-650000, 0.4949) (-639000, 0.5101) (-627000, 0.5253) (-616000, 0.5404) (-604000, 0.5555) (-593000, 0.5706) (-582000, 0.5857) (-570000, 0.6008) (-559000, 0.6158) (-547000, 0.6309) (-536000, 0.6459) (-525000, 0.6609) (-513000, 0.6759) (-502000, 0.6909) (-490000, 0.7059) (-479000, 0.7209) (-468000, 0.7359) (-456000, 0.7509) (-445000, 0.7658) (-433000, 0.7808) (-422000, 0.7958) (-410000, 0.8107) (-399000, 0.8257) (-388000, 0.8406) (-376000, 0.8555) (-365000, 0.8705) (-353000, 0.8854) (-342000, 0.9003) (-331000, 0.9153) (-319000, 0.9302) (-308000, 0.9451) (-296000, 0.96) (-285000, 0.9749) (-274000, 0.9898) (-262000, 1.0047) (-251000, 1.0196) (-239000, 1.0345) (-228000, 1.0494) (-217000, 1.0643) (-205000, 1.0792) (-194000, 1.0941) (-182000, 1.109) (-171000, 1.1239) (-160000, 1.1388) (-148000, 1.1537) (-137000, 1.1686) (-125000, 1.1834) (-114000, 1.1983) (-103000, 1.2132) (-91000, 1.2281) (-80000, 1.243) (-68000, 1.2578) (-57000, 1.2727) (-46000, 1.2876) (-34000, 1.3025) (-23000, 1.3173) (-11000, 1.3322) (0, 1.3471)} conductivity=555555.5556 magnetic_coercivity{Magnitude=-1089500A_per_meter DirComp1=1 DirComp2=0 DirComp3=0} mass_density=7500

design assm_24slot-26pole (RMxprt, Adjust-Speed Synchronous Machine, model units mm)
machine:
  Machine: FrictionLoss=0W WindLoss=0W ReferenceSpeed=2700rpm NumberOfPoles=26 RotorPosition=true ControlType=3 CircuitType=Y3
  Circuit: TriggerPulseWidth=120deg TransistorDrop=0V DiodeDrop=0V ModulationIndex=0.8 CarrierFrequencyTimes=60
  Stator: SkewWidth=0.6885 NumberOfSlots=24 LaminationSectors=0 PressBoardThickness=0mm OuterDiameter=424.5mm InnerDiameter=274.7mm Length=42.2mm StackingFactor=0.95 SteelType="AK Steel - M-15, 14mil" SlotType=3
  Rotor: OuterDiameter=273.4mm InnerDiameter=100mm Length=42.2mm SteelType="AK Steel - M-15, 14mil" PoleType=5 StackingFactor=0.95
  Shaft:
  Stator Slot: Hs0=2mm Hs1=2mm Hs2=48mm Bs0=15.9mm Bs1=20mm Bs2=20mm Rs=5mm ParallelTooth ToothWidth=17.9mm
  Stator Winding: WindingType=Whole-Coiled WindingLayers=1 ParallelBranches=1 ConductorsPerSlot=29 CoilPitch=1 EndAdjustment=0mm BaseInnerRadius=0mm TipInnerDiameter=0mm EndClearance=0mm CoilWrap=0mm SlotLiner=0.3mm WedgeThickness=0mm LayerInsulation=0mm BottomInsulation=0mm LimitedFillFactor=0.75 WdgNumberofPriodicMultipler=1 NumberOfStrands=1 WireWrap=0mm InterturnInsulation=0mm WireDiameter=5.189mm WireWidth=0mm WireThickness=0mm Gauge=4
  Rotor Pole: Embrace=0.6 Offset=0mm ShaftDiameter=0mm Bridge=1mm Rib=2mm MagnetThickness=15mm MagnetWidth=19.2mm MagnetType=Arnold_Magnetics_N50H_60C
setups:
  Setup1: ASSM Motor RatedOutputPower=47000W RatedVoltage=2200V RatedSpeed=2700rpm OperatingTemperature=75cel LoadType=ConstPower RatedPowerFactor=0.75

design assm_24slot-26pole1 (RMxprt, Adjust-Speed Synchronous Machine, model units mm)
machine:
  Machine: FrictionLoss=0W WindLoss=0W ReferenceSpeed=2700rpm NumberOfPoles=26 RotorPosition=true ControlType=3 CircuitType=Y3
  Circuit: TriggerPulseWidth=120deg TransistorDrop=0V DiodeDrop=0V ModulationIndex=0.8 CarrierFrequencyTimes=60
  Stator: SkewWidth=0 NumberOfSlots=24 LaminationSectors=0 PressBoardThickness=0mm OuterDiameter=424.5mm InnerDiameter=274.7mm Length=42.2mm StackingFactor=0.95 SteelType="AK Steel - M-15, 14mil" SlotType=3
  Rotor: OuterDiameter=273.4mm InnerDiameter=100mm Length=42.2mm SteelType="AK Steel - M-15, 14mil" PoleType=5 StackingFactor=0.95
  Shaft:
  Stator Slot: Hs0=2mm Hs1=2mm Hs2=48mm Bs0=15.9mm Bs1=20mm Bs2=20mm Rs=5mm ParallelTooth ToothWidth=17.9mm
  Stator Winding: WindingType=Whole-Coiled WindingLayers=1 ParallelBranches=1 ConductorsPerSlot=29 CoilPitch=1 EndAdjustment=0mm BaseInnerRadius=0mm TipInnerDiameter=0mm EndClearance=0mm CoilWrap=0mm SlotLiner=0.3mm WedgeThickness=0mm LayerInsulation=0mm BottomInsulation=0mm LimitedFillFactor=0.75 WdgNumberofPriodicMultipler=1 NumberOfStrands=1 WireWrap=0mm InterturnInsulation=0mm WireDiameter=5.189mm WireWidth=0mm WireThickness=0mm Gauge=4
  Rotor Pole: Embrace=0.6 Offset=0mm ShaftDiameter=0mm Bridge=1mm Rib=2mm MagnetThickness=15mm MagnetWidth=19.2mm MagnetType=Arnold_Magnetics_N50H_60C
setups:
  Setup1: ASSM Motor RatedOutputPower=47000W RatedVoltage=2400V RatedSpeed=2700rpm OperatingTemperature=75cel LoadType=ConstPower RatedPowerFactor=0.75

design assm_24slot-26pole2 (RMxprt, Adjust-Speed Synchronous Machine, model units mm)
machine:
  Machine: FrictionLoss=0W WindLoss=0W ReferenceSpeed=2700rpm NumberOfPoles=26 RotorPosition=true ControlType=3 CircuitType=Y3
  Circuit: TriggerPulseWidth=120deg TransistorDrop=0V DiodeDrop=0V ModulationIndex=0.8 CarrierFrequencyTimes=60
  Stator: SkewWidth=0 NumberOfSlots=24 LaminationSectors=0 PressBoardThickness=0mm OuterDiameter=424.5mm InnerDiameter=274.7mm Length=42.2mm StackingFactor=0.95 SteelType="AK Steel - M-15, 14mil" SlotType=3
  Rotor: OuterDiameter=273.4mm InnerDiameter=100mm Length=42.2mm SteelType="AK Steel - M-15, 14mil" PoleType=5 StackingFactor=0.95
  Shaft:
  Stator Slot: Hs0=2mm Hs1=2mm Hs2=48mm Bs0=15.9mm Bs1=20mm Bs2=20mm Rs=5mm ParallelTooth ToothWidth=17.9mm
  Stator Winding: WindingType=Whole-Coiled WindingLayers=1 ParallelBranches=1 ConductorsPerSlot=29 CoilPitch=1 EndAdjustment=0mm BaseInnerRadius=0mm TipInnerDiameter=0mm EndClearance=0mm CoilWrap=0mm SlotLiner=0.3mm WedgeThickness=0mm LayerInsulation=0mm BottomInsulation=0mm LimitedFillFactor=0.75 WdgNumberofPriodicMultipler=1 NumberOfStrands=1 WireWrap=0mm InterturnInsulation=0mm WireDiameter=5.189mm WireWidth=0mm WireThickness=0mm Gauge=4
  Rotor Pole: Embrace=0.6 Offset=0mm ShaftDiameter=0mm Bridge=1mm Rib=2mm MagnetThickness=15mm MagnetWidth=19.2mm MagnetType=Arnold_Magnetics_N50H_60C
setups:
  Setup1: ASSM Motor RatedOutputPower=47000W RatedVoltage=2400V RatedSpeed=2700rpm OperatingTemperature=75cel LoadType=ConstPower RatedPowerFactor=0.75

design assm_24slot-26pole3 (RMxprt, Adjust-Speed Synchronous Machine, model units mm)
machine:
  Machine: FrictionLoss=0W WindLoss=0W ReferenceSpeed=2700rpm NumberOfPoles=26 RotorPosition=true ControlType=3 CircuitType=Y3
  Circuit: TriggerPulseWidth=120deg TransistorDrop=0V DiodeDrop=0V ModulationIndex=0.8 CarrierFrequencyTimes=60
  Stator: SkewWidth=0 NumberOfSlots=24 LaminationSectors=0 PressBoardThickness=0mm OuterDiameter=424.5mm InnerDiameter=274.7mm Length=42.2mm StackingFactor=0.95 SteelType="AK Steel - M-15, 14mil" SlotType=3
  Rotor: OuterDiameter=273.4mm InnerDiameter=100mm Length=42.2mm SteelType="AK Steel - M-15, 14mil" PoleType=5 StackingFactor=0.95
  Shaft:
  Stator Slot: Hs0=2mm Hs1=2mm Hs2=48mm Bs0=15.9mm Bs1=20mm Bs2=20mm Rs=5mm ParallelTooth ToothWidth=17.9mm
  Stator Winding: WindingType=Whole-Coiled WindingLayers=1 ParallelBranches=1 ConductorsPerSlot=29 CoilPitch=1 EndAdjustment=0mm BaseInnerRadius=0mm TipInnerDiameter=0mm EndClearance=0mm CoilWrap=0mm SlotLiner=0.3mm WedgeThickness=0mm LayerInsulation=0mm BottomInsulation=0mm LimitedFillFactor=0.75 WdgNumberofPriodicMultipler=1 NumberOfStrands=1 WireWrap=0mm InterturnInsulation=0mm WireDiameter=5.189mm WireWidth=0mm WireThickness=0mm Gauge=4
  Rotor Pole: Embrace=0.6 Offset=0mm ShaftDiameter=0mm Bridge=1mm Rib=2mm MagnetThickness=15mm MagnetWidth=19.2mm MagnetType=Arnold_Magnetics_N50H_60C
setups:
  Setup1: ASSM Motor RatedOutputPower=47000W RatedVoltage=2400V RatedSpeed=2700rpm OperatingTemperature=75cel LoadType=ConstPower RatedPowerFactor=0.75

design assm_24slot-26pole4 (RMxprt, Adjust-Speed Synchronous Machine, model units mm)
machine:
  Machine: FrictionLoss=0W WindLoss=0W ReferenceSpeed=2700rpm NumberOfPoles=26 RotorPosition=true ControlType=3 CircuitType=Y3
  Circuit: TriggerPulseWidth=120deg TransistorDrop=0V DiodeDrop=0V ModulationIndex=0.8 CarrierFrequencyTimes=60
  Stator: SkewWidth=0 NumberOfSlots=24 LaminationSectors=0 PressBoardThickness=0mm OuterDiameter=424.5mm InnerDiameter=274.7mm Length=42.2mm StackingFactor=0.95 SteelType="AK Steel - M-15, 14mil" SlotType=3
  Rotor: OuterDiameter=273.4mm InnerDiameter=100mm Length=42.2mm SteelType="AK Steel - M-15, 14mil" PoleType=5 StackingFactor=0.95
  Shaft:
  Stator Slot: Hs0=2mm Hs1=2mm Hs2=48mm Bs0=15.9mm Bs1=20mm Bs2=20mm Rs=5mm ParallelTooth ToothWidth=17.9mm
  Stator Winding: WindingType=Whole-Coiled WindingLayers=1 ParallelBranches=1 ConductorsPerSlot=29 CoilPitch=1 EndAdjustment=0mm BaseInnerRadius=0mm TipInnerDiameter=0mm EndClearance=0mm CoilWrap=0mm SlotLiner=0.3mm WedgeThickness=0mm LayerInsulation=0mm BottomInsulation=0mm LimitedFillFactor=0.75 WdgNumberofPriodicMultipler=1 NumberOfStrands=1 WireWrap=0mm InterturnInsulation=0mm WireDiameter=5.189mm WireWidth=0mm WireThickness=0mm Gauge=4
  Rotor Pole: Embrace=0.6 Offset=0mm ShaftDiameter=0mm Bridge=1mm Rib=2mm MagnetThickness=15mm MagnetWidth=19.2mm MagnetType=Arnold_Magnetics_N50H_60C
setups:
  Setup1: ASSM Motor RatedOutputPower=47000W RatedVoltage=2400V RatedSpeed=2700rpm OperatingTemperature=75cel LoadType=ConstPower RatedPowerFactor=0.75

design assm_24slot-26pole5 (RMxprt, Adjust-Speed Synchronous Machine, model units mm)
machine:
  Machine: FrictionLoss=0W WindLoss=0W ReferenceSpeed=2700rpm NumberOfPoles=26 RotorPosition=true ControlType=3 CircuitType=Y3
  Circuit: TriggerPulseWidth=120deg TransistorDrop=0V DiodeDrop=0V ModulationIndex=0.8 CarrierFrequencyTimes=60
  Stator: SkewWidth=0 NumberOfSlots=24 LaminationSectors=0 PressBoardThickness=0mm OuterDiameter=424.5mm InnerDiameter=274.7mm Length=42.2mm StackingFactor=0.95 SteelType="AK Steel - M-15, 14mil" SlotType=3
  Rotor: OuterDiameter=273.4mm InnerDiameter=100mm Length=42.2mm SteelType="AK Steel - M-15, 14mil" PoleType=5 StackingFactor=0.95
  Shaft:
  Stator Slot: Hs0=2mm Hs1=2mm Hs2=48mm Bs0=15.9mm Bs1=20mm Bs2=20mm Rs=5mm ParallelTooth ToothWidth=17.9mm
  Stator Winding: WindingType=Whole-Coiled WindingLayers=1 ParallelBranches=1 ConductorsPerSlot=29 CoilPitch=1 EndAdjustment=0mm BaseInnerRadius=0mm TipInnerDiameter=0mm EndClearance=0mm CoilWrap=0mm SlotLiner=0.3mm WedgeThickness=0mm LayerInsulation=0mm BottomInsulation=0mm LimitedFillFactor=0.75 WdgNumberofPriodicMultipler=1 NumberOfStrands=1 WireWrap=0mm InterturnInsulation=0mm WireDiameter=5.189mm WireWidth=0mm WireThickness=0mm Gauge=4
  Rotor Pole: Embrace=0.6 Offset=0mm ShaftDiameter=0mm Bridge=1mm Rib=2mm MagnetThickness=15mm MagnetWidth=19.2mm MagnetType=Arnold_Magnetics_N50H_60C
setups:
  Setup1: ASSM Motor RatedOutputPower=47000W RatedVoltage=2400V RatedSpeed=2700rpm OperatingTemperature=75cel LoadType=ConstPower RatedPowerFactor=0.75
